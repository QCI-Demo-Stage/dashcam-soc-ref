// Auto-generated by scripts/reggen.py from csv/register_spec.csv — do not edit.
// IP: iomux  base: 0x10000300

addrmap iomux_csr {
    name = "iomux";
    desc = "I/O multiplexer";
    default regwidth = 32;
    default accesswidth = 32;

    reg {
        name = "CTRL";
        regwidth = 32;
        field {
            name = "data";
            sw = rw;
            hw = r;
        } data[31:0];
    } CTRL @ 0x0;

};
