// Auto-generated by scripts/reggen.py from csv/register_spec.csv — do not edit.
// IP: irq  base: 0x10000200

addrmap irq_csr {
    name = "irq";
    desc = "Interrupt controller";
    default regwidth = 32;
    default accesswidth = 32;

    reg {
        name = "ENABLE";
        regwidth = 32;
        field {
            name = "data";
            sw = rw;
            hw = r;
        } data[31:0];
    } ENABLE @ 0x0;

    reg {
        name = "PENDING";
        regwidth = 32;
        field {
            name = "data";
            sw = rw;
            hw = r;
        } data[31:0];
    } PENDING @ 0x4;

    reg {
        name = "STATUS";
        regwidth = 32;
        field {
            name = "data";
            sw = r;
            hw = r;
        } data[31:0];
    } STATUS @ 0x8;

};
