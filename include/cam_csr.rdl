// Auto-generated by scripts/reggen.py from csv/register_spec.csv — do not edit.
// IP: cam  base: 0x10000000

addrmap cam_csr {
    name = "cam";
    desc = "Camera capture control";
    default regwidth = 32;
    default accesswidth = 32;

    reg {
        name = "CTRL";
        regwidth = 32;
        field {
            name = "data";
            sw = rw;
            hw = r;
        } data[31:0];
    } CTRL @ 0x0;

    reg {
        name = "STATUS";
        regwidth = 32;
        field {
            name = "data";
            sw = r;
            hw = r;
        } data[31:0];
    } STATUS @ 0x4;

    reg {
        name = "FRAME_W";
        regwidth = 32;
        field {
            name = "data";
            sw = rw;
            hw = r;
        } data[31:0];
    } FRAME_W @ 0x8;

    reg {
        name = "FRAME_H";
        regwidth = 32;
        field {
            name = "data";
            sw = rw;
            hw = r;
        } data[31:0];
    } FRAME_H @ 0xC;

};
