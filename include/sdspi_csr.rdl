// Auto-generated by scripts/reggen.py from csv/register_spec.csv — do not edit.
// IP: sdspi  base: 0x10000400

addrmap sdspi_csr {
    name = "sdspi";
    desc = "SD-SPI controller stub";
    default regwidth = 32;
    default accesswidth = 32;

    reg {
        name = "CTRL";
        regwidth = 32;
        field {
            name = "data";
            sw = rw;
            hw = r;
        } data[31:0];
    } CTRL @ 0x0;

    reg {
        name = "STATUS";
        regwidth = 32;
        field {
            name = "data";
            sw = r;
            hw = r;
        } data[31:0];
    } STATUS @ 0x4;

    reg {
        name = "DATA";
        regwidth = 32;
        field {
            name = "data";
            sw = rw;
            hw = r;
        } data[31:0];
    } DATA @ 0x8;

};
