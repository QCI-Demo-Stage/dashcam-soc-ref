// Auto-generated by scripts/reggen.py from csv/register_spec.csv — do not edit.
// IP: dma  base: 0x10000100

addrmap dma_csr {
    name = "dma";
    desc = "Pixel DMA engine";
    default regwidth = 32;
    default accesswidth = 32;

    reg {
        name = "CTRL";
        regwidth = 32;
        field {
            name = "data";
            sw = rw;
            hw = r;
        } data[31:0];
    } CTRL @ 0x0;

    reg {
        name = "STATUS";
        regwidth = 32;
        field {
            name = "data";
            sw = r;
            hw = r;
        } data[31:0];
    } STATUS @ 0x4;

    reg {
        name = "DST_ADDR";
        regwidth = 32;
        field {
            name = "data";
            sw = rw;
            hw = r;
        } data[31:0];
    } DST_ADDR @ 0x8;

    reg {
        name = "LENGTH";
        regwidth = 32;
        field {
            name = "data";
            sw = rw;
            hw = r;
        } data[31:0];
    } LENGTH @ 0xC;

};
