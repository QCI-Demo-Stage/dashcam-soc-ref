// Dashcam SoC Register Map
// Auto-generated by scripts/reggen.py from csv/register_spec.csv — do not edit.
// Wishbone B4; CSR @ 0x10000000; SRAM @ 0x20000000
// Address-map style aligned with OpenTitan register conventions.

addrmap dashcam_soc {
    name = "Dashcam SoC";
    desc = "Wishbone B4 address map for CSR and on-chip SRAM windows";
    default regwidth = 32;
    default accesswidth = 32;

    reg {
        name = "CAM_CTRL";
        regwidth = 32;
        field {
            name = "data";
            sw = rw;
            hw = r;
        } data[31:0];
    } CAM_CTRL @ 0x10000000;

    reg {
        name = "CAM_STATUS";
        regwidth = 32;
        field {
            name = "data";
            sw = r;
            hw = r;
        } data[31:0];
    } CAM_STATUS @ 0x10000004;

    reg {
        name = "CAM_FRAME_W";
        regwidth = 32;
        field {
            name = "data";
            sw = rw;
            hw = r;
        } data[31:0];
    } CAM_FRAME_W @ 0x10000008;

    reg {
        name = "CAM_FRAME_H";
        regwidth = 32;
        field {
            name = "data";
            sw = rw;
            hw = r;
        } data[31:0];
    } CAM_FRAME_H @ 0x1000000C;

    reg {
        name = "DMA_CTRL";
        regwidth = 32;
        field {
            name = "data";
            sw = rw;
            hw = r;
        } data[31:0];
    } DMA_CTRL @ 0x10000100;

    reg {
        name = "DMA_STATUS";
        regwidth = 32;
        field {
            name = "data";
            sw = r;
            hw = r;
        } data[31:0];
    } DMA_STATUS @ 0x10000104;

    reg {
        name = "DMA_DST_ADDR";
        regwidth = 32;
        field {
            name = "data";
            sw = rw;
            hw = r;
        } data[31:0];
    } DMA_DST_ADDR @ 0x10000108;

    reg {
        name = "DMA_LENGTH";
        regwidth = 32;
        field {
            name = "data";
            sw = rw;
            hw = r;
        } data[31:0];
    } DMA_LENGTH @ 0x1000010C;

    reg {
        name = "IRQ_ENABLE";
        regwidth = 32;
        field {
            name = "data";
            sw = rw;
            hw = r;
        } data[31:0];
    } IRQ_ENABLE @ 0x10000200;

    reg {
        name = "IRQ_PENDING";
        regwidth = 32;
        field {
            name = "data";
            sw = rw;
            hw = r;
        } data[31:0];
    } IRQ_PENDING @ 0x10000204;

    reg {
        name = "IRQ_STATUS";
        regwidth = 32;
        field {
            name = "data";
            sw = r;
            hw = r;
        } data[31:0];
    } IRQ_STATUS @ 0x10000208;

    reg {
        name = "IOMUX_CTRL";
        regwidth = 32;
        field {
            name = "data";
            sw = rw;
            hw = r;
        } data[31:0];
    } IOMUX_CTRL @ 0x10000300;

    reg {
        name = "SDSPI_CTRL";
        regwidth = 32;
        field {
            name = "data";
            sw = rw;
            hw = r;
        } data[31:0];
    } SDSPI_CTRL @ 0x10000400;

    reg {
        name = "SDSPI_STATUS";
        regwidth = 32;
        field {
            name = "data";
            sw = r;
            hw = r;
        } data[31:0];
    } SDSPI_STATUS @ 0x10000404;

    reg {
        name = "SDSPI_DATA";
        regwidth = 32;
        field {
            name = "data";
            sw = rw;
            hw = r;
        } data[31:0];
    } SDSPI_DATA @ 0x10000408;

    external mem {
        name = "SRAM";
        desc = "On-chip SRAM window (4 KiB smoke model)";
        memwidth = 32;
        mementries = 1024;
    } SRAM @ 0x20000000;

};
